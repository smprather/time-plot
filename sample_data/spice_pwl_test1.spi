* comment

i1 foo1 0 pwl(0 0 10n 5m 20n 7m)
i2 foo2 0 pwl 0 0 10n 5m 20n 7m
i3 foo3 0 pwl
+ 0 0
+ 10n 5m
+ 20n 7m
i4 foo2 0 pwl 0 0 10n
+ 5m 20n 7m
